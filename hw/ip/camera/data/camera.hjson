{ name: "camera"
  clock_primary: "clk_i"
  bus_interfaces: [
    { protocol: "reg_iface", direction: "device" }
  ]
  regwidth: "32"

  registers: [
    { name: "CONTROL"
      desc: "Control register for flash controller"
      swaccess: "rw"
      hwaccess: "hrw"
      fields: [
        { bits: "0", name: "START", desc: "Start operation", resval: "0x0" }
      ]
    }

    { name: "STATUS"
      desc: "Status register for flash controller"
      swaccess: "rw"
      hwaccess: "hrw"
      fields: [
        { bits: "0", name: "READY", desc: "Ready for new operation", resval: "0x0" }
      ]
    }
  ]
}
